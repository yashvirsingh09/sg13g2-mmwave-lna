* ==============================================================================
* SMACD 2027: Linearity (P1dB & Fourier Analysis) Testbench (24-28 GHz LNA)
* Technology: IHP SG13G2 (130 nm SiGe BiCMOS)
* SPDX-License-Identifier: Apache-2.0
* ==============================================================================

.include ../lna_top_sim.spice
.include ihp_models_portable.spice

* Power Supply & DC Biasing (Cascodes self-biased via on-chip R3/R4 to VCC)
VCC VCC 0 DC 1.80
V_B1 VBIAS1 0 DC 0.900
V_B2 VBIAS2 0 DC 0.890

* Device Under Test (6-Port Interface: GND, VCC, VBIAS1, VBIAS2, RFIN, RFOUT)
XDUT 0 VCC VBIAS1 VBIAS2 RFIN RFOUT lna_top

* 28.0 GHz Sinusoidal RF Input (-40 dBm into 50 Ohm: Vpk = 6.32 mV, Source Vpk = 12.65 mV)
VIN IN_SRC 0 DC 0 SIN(0 12.649m 28.0g)
RS1 IN_SRC RFIN 50.0

* Output 50-Ohm Load
RL2 RFOUT 0 50.0

* Transient Analysis: 0.5 ps time step for high-frequency resolution
.tran 0.5p 1.4n 0.8n

.control
set filetype=ascii
run
fourier 28.0g v(rfout)
let v_out = v(rfout)
write tb_linearity.raw v_out
quit
.endc

.end
