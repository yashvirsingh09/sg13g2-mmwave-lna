* ==============================================================================
* IHP SG13G2: Portable Model Includes & Subcircuits for Simulation Testbenches
* Technology: IHP SG13G2 130 nm SiGe BiCMOS (Commit e73adb4)
* SPDX-License-Identifier: Apache-2.0
* ==============================================================================

.lib "../../ihp_pdk/ihp-sg13g2/libs.tech/ngspice/models/cornerHBT.lib" hbt_typ
.include "../../ihp_pdk/ihp-sg13g2/libs.tech/ngspice/models/sg13g2_hbt_mod.lib"
.lib "../../ihp_pdk/ihp-sg13g2/libs.tech/ngspice/models/cornerCAP.lib" cap_typ
.options rshunt=1e12

* High-voltage poly resistor subcircuit (rhigh):
.param r_high_r = '1360.0 * (0.96 / 0.5)'
.subckt rhigh 1 2 bn w=0.5u l=0.96u ps=0u b=0 m=1
R1 1 2 'r_high_r'
Csub1 1 bn 0.5f
Csub2 2 bn 0.5f
.ends rhigh

* RF MIM capacitor subcircuit (rfcmim):
.subckt rfcmim 1 2 bn w=7u l=7u A=49p P=28u m=1 wfeed=3u
Xcap 1 2 bn cap_rfcmim w=w l=l wfeed=wfeed
.ends rfcmim

* 2-turn spiral planar inductor subcircuit (inductor3):
.subckt inductor3 1 2 3 sub w=2u s=2.1u d=25.85u nr_r=2
.param L_val = 221.5p
.param r_ser = 1.386
.param l_half = 'L_val / 2'
Rser1 1 1a 'r_ser/2'
L1 1a 2 'l_half'
Rser2 2 2a 'r_ser/2'
L2 2a 3 'l_half'
Cox1 1 sub 4.0f
Cox2 3 sub 4.0f
Cp 1 3 2.0f
.ends inductor3
