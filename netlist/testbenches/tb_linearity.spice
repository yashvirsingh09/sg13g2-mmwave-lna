* ==============================================================================
* SMACD 2027: Linearity (P1dB & IIP3) Testbench (24-28 GHz LNA)
* Technology: IHP SG13G2 (130 nm SiGe BiCMOS)
* SPDX-License-Identifier: Apache-2.0
* ==============================================================================

.include ../lna_top.spice
.include ihp_models_portable.spice

VCC VCC 0 DC 1.8
VGND GND 0 DC 0.0

* 2-Tone RF Input Source at 28.00 GHz and 28.05 GHz (50 MHz spacing)
VIN1 IN1 0 SIN(0 0.01 28.00g)
VIN2 IN2 IN1 SIN(0 0.01 28.05g)
R_SRC IN2 IN_DUT 50.0

XDUT GND LA LA1 LA2 LB VCC LC LC1 LC2 IN_DUT OUT_PAD VCC VCC lna_top
R_LOAD OUT_PAD 0 50.0

* Transient simulation for FFT spectral intermodulation analysis
.tran 1p 20000p 10000p 1p

.control
run
let v_out = v(out_pad)
write tb_linearity.raw v_out time
quit
.endc

.end
