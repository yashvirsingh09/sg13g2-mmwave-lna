* ==============================================================================
* SMACD 2027: Multi-Corner PVT Characterization Testbench (24-28 GHz LNA)
* Technology: IHP SG13G2 (130 nm SiGe BiCMOS)
* SPDX-License-Identifier: Apache-2.0
* ==============================================================================

* Evaluates:
* TT: Typical HBT (hbt_typ), VCC = 1.80V, Temp = 27 C
* FF: Fast HBT (hbt_bcs), VCC = 1.98V, Temp = -40 C
* SS: Slow HBT (hbt_wcs), VCC = 1.62V, Temp = 85 C

.include ../lna_top.spice

VCC VCC 0 DC 1.8
VGND GND 0 DC 0.0

P1 IN_PAD 0 port=1 z0=50
P2 OUT_PAD 0 port=2 z0=50

XDUT IN_PAD OUT_PAD VCC GND lna_top

.sp dec 50 20g 35g 1

.control
* TT Run
set temp = 27
alter vcc = 1.80
run
let s21_tt = db(S_2_1)

* FF Run
set temp = -40
alter vcc = 1.98
run
let s21_ff = db(S_2_1)

* SS Run
set temp = 85
alter vcc = 1.62
run
let s21_ss = db(S_2_1)

write tb_corners.raw s21_tt s21_ff s21_ss frequency
quit
.endc

.end
