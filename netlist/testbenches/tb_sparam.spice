* ==============================================================================
* SMACD 2027: 2-Port S-Parameter Simulation Testbench (24-28 GHz LNA)
* Technology: IHP SG13G2 (130 nm SiGe BiCMOS)
* Standard Ngspice 2-Port Scattering Analysis Testbench
* SPDX-License-Identifier: Apache-2.0
* ==============================================================================

.include ../lna_top.spice
.include ihp_models_portable.spice

* Power Supply
VCC VCC 0 DC 1.8
VGND GND 0 DC 0.0

* Device Under Test
XDUT GND LA LA1 LA2 LB VCC LC LC1 LC2 IN_PAD OUT_PAD VCC VCC lna_top

* 2-Port S-Parameter Analysis via Ngspice Native RF Port Elements (Ngspice 30+)
P1 IN_PAD 0 port=1 z0=50
P2 OUT_PAD 0 port=2 z0=50

.sp dec 100 10g 40g 1

.control
run
* S-parameters are automatically computed by the .sp analysis engine:
* S11, S21, S12, S22
write tb_sparam.raw S11 S21 S12 S22
quit
.endc

.end
