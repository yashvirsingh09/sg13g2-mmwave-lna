* ==============================================================================
* SMACD 2027: Noise Figure Analysis Testbench (24-28 GHz LNA)
* Technology: IHP SG13G2 (130 nm SiGe BiCMOS)
* SPDX-License-Identifier: Apache-2.0
* ==============================================================================

.include ../lna_top_sim.spice
.include ihp_models_portable.spice

* Power Supply & DC Biasing (Authentic: Cascodes self-biased via on-chip R3/R4 to VCC)
VCC VCC 0 DC 1.80
V_B1 VBIAS1 0 DC 0.900
V_B2 VBIAS2 0 DC 0.890

* Device Under Test (6-Port Interface: GND, VCC, VBIAS1, VBIAS2, RFIN, RFOUT)
XDUT 0 VCC VBIAS1 VBIAS2 RFIN RFOUT lna_top

* Port 1 Input Drive: 50 Ohm source
VIN IN_SRC 0 DC 0 AC 1.0
RS1 IN_SRC RFIN 50.0

* Port 2 Termination: 50 Ohm load
RL2 RFOUT 0 50.0

* Noise Analysis (20 GHz to 35 GHz)
.noise v(RFOUT) VIN lin 151 20g 35g

.control
set filetype=ascii
run
setplot noise1
let inoise_sq = inoise_spectrum * inoise_spectrum
let nf_db = 10.0 * log10(inoise_sq / (4.0 * 1.380649e-23 * 290.0 * 50.0))
write tb_noise_figure.raw nf_db inoise_spectrum onoise_spectrum
print nf_db[80]
quit
.endc

.end
