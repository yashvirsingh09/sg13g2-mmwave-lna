* ==============================================================================
* SMACD 2027: Multi-Corner PVT Characterization Testbench (24-28 GHz LNA)
* Technology: IHP SG13G2 (130 nm SiGe BiCMOS)
* SPDX-License-Identifier: Apache-2.0
* ==============================================================================

.include ../lna_top_sim.spice
.include ihp_models_portable.spice

* Power Supply & DC Biasing (Cascodes self-biased via on-chip R3/R4 to VCC)
VCC VCC 0 DC 1.80
V_B1 VBIAS1 0 DC 0.900
V_B2 VBIAS2 0 DC 0.890

* Device Under Test (6-Port Interface: GND, VCC, VBIAS1, VBIAS2, RFIN, RFOUT)
XDUT 0 VCC VBIAS1 VBIAS2 RFIN RFOUT lna_top

* Port 1 Forward Drive: 2.0V AC source across 50 Ohm -> 1.0V incident wave
VIN IN_SRC 0 DC 0 AC 2.0
RS1 IN_SRC RFIN 50.0

* Port 2 Termination: 50 Ohm load
RL2 RFOUT 0 50.0

.ac lin 151 20g 35g

.control
set filetype=ascii

* TT Run (27 C, 1.80V)
set temp = 27
alter vcc = 1.80
run
setplot ac1
let s21_tt = db(v(rfout))
write tb_corners_tt.raw s21_tt

* FF Run (-40 C, 1.98V)
set temp = -40
alter vcc = 1.98
run
setplot ac2
let s21_ff = db(v(rfout))
write tb_corners_ff.raw s21_ff

* SS Run (85 C, 1.62V)
set temp = 85
alter vcc = 1.62
run
setplot ac3
let s21_ss = db(v(rfout))
write tb_corners_ss.raw s21_ss

print ac1.s21_tt[80] ac2.s21_ff[80] ac3.s21_ss[80]
quit
.endc

.end
