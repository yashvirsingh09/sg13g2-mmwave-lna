* ==============================================================================
* SMACD 2027: Noise Analysis Testbench
* Circuit: 20-Gbps SiGe-BiCMOS Optical TIA (IHP SG13G2)
* SPDX-License-Identifier: Apache-2.0
* ==============================================================================

.include ../tia_top.spice

* Power Supplies
VDD VDD 0 DC 2.5
VSS VSS 0 DC 0.0

* Input Current Source with Photodiode Capacitance
IIN 0 IN_PAD DC 0 AC 1u
CPD IN_PAD 0 40f

* Top-Level DUT
XDUT IN_PAD OUT_P OUT_N VDD VSS tia_top

* External 50-Ohm Loads
RLOAD_P OUT_P 0 50
RLOAD_N OUT_N 0 50

* Noise Simulation Directive (Noise referenced to output differential voltage and input current source IIN)
.noise v(out_p, out_n) IIN dec 50 10meg 25g

.control
run
* Save noise spectral data
write tb_noise.raw onoise_spectrum inoise_spectrum frequency
quit
.endc

.end
