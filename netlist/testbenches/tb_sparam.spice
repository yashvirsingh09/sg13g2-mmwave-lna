* ==============================================================================
* SMACD 2027: 2-Port S-Parameter Simulation Testbench (24-28 GHz LNA)
* Technology: IHP SG13G2 (130 nm SiGe BiCMOS)
* SPDX-License-Identifier: Apache-2.0
* ==============================================================================

.include ../lna_top_sim.spice
.include ihp_models_portable.spice

* Power Supply & DC Biasing (Authentic: Cascodes self-biased via on-chip R3/R4 to VCC)
VCC VCC 0 DC 1.80
V_B1 VBIAS1 0 DC 0.900
V_B2 VBIAS2 0 DC 0.890

* Device Under Test (6-Port Interface: GND, VCC, VBIAS1, VBIAS2, RFIN, RFOUT)
XDUT 0 VCC VBIAS1 VBIAS2 RFIN RFOUT lna_top

* Port 1 Forward Drive: 2.0V AC source across 50 Ohm -> 1.0V incident wave
VIN IN_SRC 0 DC 0 AC 2.0
RS1 IN_SRC RFIN 50.0

* Port 2 Termination: 50 Ohm load
RL2 RFOUT 0 50.0

.ac lin 151 20g 35g

.control
set filetype=ascii
op
let pdc_mw = (-i(VCC) * 1.80 + -i(V_B1) * 0.900 + -i(V_B2) * 0.890) * 1e3
print pdc_mw

run
let s21_db = db(v(rfout))
let s11_db = db(v(rfin) - 1.0)
write tb_sparam.raw s21_db s11_db
print s21_db[80] s11_db[80]
quit
.endc

.end
