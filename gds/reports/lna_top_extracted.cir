* Extracted by KLayout with SG13G2 LVS runset on : 16/11/2026 13:41

.SUBCKT lna_top LA LA$1 LA$2 LB LB$1 LB$2 LC LC$1 LC$2
Q$1 \$22 \$21 \$27 \$1 npn13G2 we=70n le=900n Nx=1 m=1
Q$2 \$49 \$48 \$57 \$1 npn13G2 we=70n le=900n Nx=1 m=1
Q$3 \$20 \$25 \$26 \$1 npn13G2 we=70n le=900n Nx=1 m=1
Q$4 \$50 \$51 \$58 \$1 npn13G2 we=70n le=900n Nx=1 m=1
Q$5 \$144 \$143 \$152 \$1 npn13G2 we=70n le=900n Nx=1 m=1
Q$6 \$146 \$145 \$154 \$1 npn13G2 we=70n le=900n Nx=1 m=1
R$7 \$151 \$162 \$1 rhigh w=0.5u l=0.96u ps=0u b=0 m=1
R$8 \$153 \$163 \$1 rhigh w=0.5u l=0.96u ps=0u b=0 m=1
C$9 \$74 \$68 \$1 rfcmim w=7u l=7u A=49p P=28u m=1 wfeed=3u
C$10 \$161 \$157 \$1 rfcmim w=7u l=7u A=49p P=28u m=1 wfeed=3u
C$11 \$73 \$67 \$1 rfcmim w=7u l=7u A=49p P=28u m=1 wfeed=3u
C$12 \$164 \$158 \$1 rfcmim w=7u l=7u A=49p P=28u m=1 wfeed=3u
L$13 LA LC LB \$1 inductor3 w=2u s=2.1u d=25.85u nr_r=2
L$14 LA$1 LC$1 LB$1 \$1 inductor3 w=2u s=2.1u d=25.85u nr_r=2
L$15 LA$2 LC$2 LB$2 \$1 inductor3 w=2u s=2.1u d=25.85u nr_r=2
.ENDS lna_top
