* ==============================================================================
* IHP SG13G2: Portable Physical 2-pi Subcircuit Model for inductor3
* Parameterized for w=2um, s=2.1um, d=25.85um, nr_r=2 (L = 400 pH, Q ~ 18 @ 28 GHz)
* SPDX-License-Identifier: Apache-2.0
* ==============================================================================

.subckt inductor3 1 2 3 sub w=2u s=2.1u d=25.85u nr_r=2
* Terminals: 1 (LA), 2 (LC tap), 3 (LB), sub (Substrate ground)
* Half-coil 1:
L1 1 2 200p Rser=2.1
Cox1 1 sub 4.0f
Rsub1 sub sub_int1 150.0
Csub1 sub_int1 0 2.5f

* Half-coil 2:
L2 2 3 200p Rser=2.1
Cox2 3 sub 4.0f
Rsub2 sub sub_int2 150.0
Csub2 sub_int2 0 2.5f

* Inter-turn coupling capacitance:
Cp 1 3 2.0f
.ends inductor3
