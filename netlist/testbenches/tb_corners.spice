* ==============================================================================
* SMACD 2027: Multi-Corner Process & Temperature Characterization Testbench
* Circuit: 20-Gbps SiGe-BiCMOS Optical TIA (IHP SG13G2)
* SPDX-License-Identifier: Apache-2.0
* ==============================================================================

* Corner definitions:
* TT: Typical HBT, Typical MOS, Typical Res, Typical Cap (27 C, VDD = 2.50V)
* FF: Fast HBT, Fast MOS, Low Res, Low Cap (-40 C, VDD = 2.75V)
* SS: Slow HBT, Slow MOS, High Res, High Cap (+85 C, VDD = 2.25V)
* FS: Fast HBT, Slow MOS (+27 C, VDD = 2.50V)
* SF: Slow HBT, Fast MOS (+27 C, VDD = 2.50V)

.include ../tia_top.spice

VDD VDD 0 DC 2.5
VSS VSS 0 DC 0.0

IIN 0 IN_PAD DC 0 AC 1u
CPD IN_PAD 0 40f

XDUT IN_PAD OUT_P OUT_N VDD VSS tia_top

RLOAD_P OUT_P 0 50
RLOAD_N OUT_N 0 50

.ac dec 50 10meg 40g

.control
let corners = 5
* TT
alter vdd = 2.50
set temp = 27
run
let zt_tt = 20 * log10(abs(v(out_p, out_n) / 1e-6))

* FF
alter vdd = 2.75
set temp = -40
run
let zt_ff = 20 * log10(abs(v(out_p, out_n) / 1e-6))

* SS
alter vdd = 2.25
set temp = 85
run
let zt_ss = 20 * log10(abs(v(out_p, out_n) / 1e-6))

write tb_corners.raw zt_tt zt_ff zt_ss frequency
quit
.endc

.end
