* ==============================================================================
* SMACD 2027 Open-Source Design Challenge
* Circuit: Top-Level 24-28 GHz 2-Stage SiGe-BiCMOS Low-Noise Amplifier
* Technology: IHP SG13G2 130nm SiGe BiCMOS (fT = 300 GHz)
* SPDX-License-Identifier: Apache-2.0
* ==============================================================================

.subckt lna_top GND LA LA$1 LA$2 LB LB|VCC LC LC$1 LC$2 RFIN RFOUT VBIAS1 VBIAS2

* --- Active HBT Transistors ---
* Stage 1 Common-Emitter Q1:
Q1 CAS1_MID LB GND GND npn13G2 we=70n le=900n Nx=1
* Stage 1 Cascode Common-Base Q2:
Q3 LA$1 VBIAS1 CAS1_MID GND npn13G2 we=70n le=900n Nx=1
* Stage 2 Common-Emitter Q3:
Q2 CAS2_MID Q3_B GND GND npn13G2 we=70n le=900n Nx=1
* Stage 2 Cascode Common-Base Q4:
Q4 LA$2 VBIAS2 CAS2_MID GND npn13G2 we=70n le=900n Nx=1

* --- Bias Resistors ---
R1 LB VBIAS1 GND rhigh w=0.5u l=0.96u
R2 Q3_B VBIAS2 GND rhigh w=0.5u l=0.96u

* --- MIM Capacitors ---
* Input DC Blocking Cin:
C1 RFIN LA GND rfcmim w=7u l=7u wfeed=3u
* Interstage DC Blocking Cint:
C2 LA$1 Q3_B GND rfcmim w=7u l=7u wfeed=3u
* Output DC Blocking Cout:
C3 LA$2 RFOUT GND rfcmim w=7u l=7u wfeed=3u
* VCC Supply Decoupling (Cbyp1 + Cbyp2):
C4 LB|VCC GND GND rfcmim w=7u l=7u m=2 wfeed=3u

* --- Spiral Inductors ---
* Input Base Matching Inductor Lg1:
L1 LA LC LB GND inductor3 w=2u s=2.1u d=25.85u nr_r=2
* Interstage Load Inductor Lint:
L2 LA$1 LC$1 LB|VCC GND inductor3 w=2u s=2.1u d=25.85u nr_r=2
* Output Load Inductor Ld2:
L3 LA$2 LC$2 LB|VCC GND inductor3 w=2u s=2.1u d=25.85u nr_r=2

.ends lna_top
