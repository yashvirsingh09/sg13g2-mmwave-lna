* ==============================================================================
* SMACD 2027 Open-Source Design Challenge
* Circuit: 50-Ohm Matched High-Speed CML Output Buffer
* Technology: IHP SG13G2 130nm SiGe BiCMOS (fT = 300 GHz)
* SPDX-License-Identifier: Apache-2.0
* ==============================================================================

.subckt output_buffer IN_P IN_N OUT_P OUT_N VDD VSS VBIAS_BUF
* IN_P, IN_N: Differential input voltages from TIA core / replica
* OUT_P, OUT_N: Differential 50-Ohm back-terminated output nodes
* VDD: 2.5V Supply
* VSS: Ground
* VBIAS_BUF: Bias voltage for tail current source

* ------------------------------------------------------------------------------
* Differential Pair with Degeneration (SiGe HBTs npn13G2 Nx=4)
* ------------------------------------------------------------------------------
XQ_P C_P IN_P E_P VSS npn13G2 Nx=4
XQ_N C_N IN_N E_N VSS npn13G2 Nx=4

* Degenerative resistor for linearity and bandwidth extension
XR_DEG E_P E_N VSS rsil w=1.0u l=2.0u

* Tail Current Source
XM_TAIL_P E_P VBIAS_BUF VSS VSS sg13_lv_nmos w=20u l=0.5u ng=4
XM_TAIL_N E_N VBIAS_BUF VSS VSS sg13_lv_nmos w=20u l=0.5u ng=4

* ------------------------------------------------------------------------------
* 50-Ohm Precision Back-Termination Resistors (R_LOAD = 50 Ohms)
* Using silicided poly resistors (rsil) for low parasitic inductance
* ------------------------------------------------------------------------------
XR_L1 VDD C_P VSS rsil w=2.0u l=14.0u
XR_L2 VDD C_N VSS rsil w=2.0u l=14.0u

* Output coupling / series connection
R_P C_P OUT_P 1
R_N C_N OUT_N 1

.ends output_buffer
