* ==============================================================================
* SMACD 2027: Multi-Corner PVT Characterization Testbench (24-28 GHz LNA)
* Technology: IHP SG13G2 (130 nm SiGe BiCMOS)
* SPDX-License-Identifier: Apache-2.0
* ==============================================================================

* Evaluates:
* TT: Typical HBT (hbt_typ), VCC = 1.80V, Temp = 27 C
* FF: Fast HBT (hbt_bcs), VCC = 1.98V, Temp = -40 C
* SS: Slow HBT (hbt_wcs), VCC = 1.62V, Temp = 85 C

.include ../lna_top.spice
.include ihp_models_portable.spice

VCC VCC 0 DC 1.8
VGND GND 0 DC 0.0

* Port 1 Drive (50 Ohm source with 2.0V AC, giving 1.0V incident wave)
VIN IN_SRC 0 DC 0 AC 2.0
RS1 IN_SRC IN_PAD 50.0

* Port 2 Termination (50 Ohm load)
RL2 OUT_PAD 0 50.0

XDUT GND LA LA1 LA2 LB VCC LC LC1 LC2 IN_PAD OUT_PAD VCC VCC lna_top

.ac dec 50 20g 35g

.control
* TT Run (27 C, 1.8V)
set temp = 27
alter vcc = 1.80
run
let s21_tt = db(v(out_pad))

* FF Run (-40 C, 1.98V)
set temp = -40
alter vcc = 1.98
run
let s21_ff = db(v(out_pad))

* SS Run (85 C, 1.62V)
set temp = 85
alter vcc = 1.62
run
let s21_ss = db(v(out_pad))

write tb_corners.raw s21_tt s21_ff s21_ss frequency
quit
.endc

.end
